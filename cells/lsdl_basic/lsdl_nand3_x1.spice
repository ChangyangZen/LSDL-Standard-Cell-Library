* lsdl_nand3_x1 — LSDL NAND3, drive strength X1.
* Paper Fig. 1 (Belluomini et al.). 3-NMOS series eval tree.
* Out = !(A1 & A2 & A3).  dyn discharges only when A1=A2=A3=1.
* Internal stack nodes nint1, nint2 named for charge-sharing probing.
* Eval NMOS width 1.0u (stack-height-3 scaling vs nand2's 0.8u).
* GF180MCU 5V: pfet_05v0 (Lmin=0.5u), nfet_05v0 (Lmin=0.6u).

.SUBCKT lsdl_nand3_x1 A1 A2 A3 Clk Out VPWR VGND

* Precharge
XPRE      dyn        Clk   VPWR       VPWR  pfet_05v0  W=1.0u  L=0.5u

* 3-series eval tree: dyn -> A1 -> nint1 -> A2 -> nint2 -> A3 -> foot_top
XNA       dyn        A1    nint1      VGND  nfet_05v0  W=1.0u  L=0.6u
XNB       nint1      A2    nint2      VGND  nfet_05v0  W=1.0u  L=0.6u
XNC       nint2      A3    foot_top   VGND  nfet_05v0  W=1.0u  L=0.6u
XFOOT     foot_top   Clk   VGND       VGND  nfet_05v0  W=1.0u  L=0.6u

* Predriver pair (dyn -> out_b)
XPDRVP    out_b      dyn   VPWR       VPWR  pfet_05v0  W=3.0u  L=0.5u
XHDR      hdr_src    Clk   VGND       VGND  nfet_05v0  W=0.8u  L=0.6u
XPDRVN    out_b      dyn   hdr_src    VGND  nfet_05v0  W=0.4u  L=0.6u

* Feedback keeper + cut feedback
XFBP      cut_fb_src Out   VPWR       VPWR  pfet_05v0  W=0.5u  L=0.5u
XCUTFB    out_b      Clk   cut_fb_src VPWR  pfet_05v0  W=0.5u  L=0.5u
XFBN      out_b      Out   VGND       VGND  nfet_05v0  W=0.5u  L=0.6u

* Output driver pair (out_b -> Out)
XODRVP    Out        out_b VPWR       VPWR  pfet_05v0  W=1.5u  L=0.5u
XODRVN    Out        out_b VGND       VGND  nfet_05v0  W=0.9u  L=0.6u

.ENDS lsdl_nand3_x1
