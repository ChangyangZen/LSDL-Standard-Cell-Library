* lsdl_nand2_x1 — LSDL NAND2, drive strength X1.
* Paper Fig. 1 (Belluomini et al., IBM J. Res. Dev. 50:2/3, 2006).
* 2-NMOS series evaluation tree: dyn pulls down only when A1=A2=1.
* Out = !(A1 & A2)
*
* GF180MCU 5V devices: pfet_05v0 (Lmin=0.5u), nfet_05v0 (Lmin=0.6u).
* Both are SUBCKTs in the PDK model file — instantiated with X prefix.

.SUBCKT lsdl_nand2_x1 A1 A2 Clk Out VPWR VGND

* ---------------------------------------------------------------
* Precharge stage
* ---------------------------------------------------------------
* Precharge device: PMOS, gate=Clk.
XPRE      dyn        Clk   VPWR       VPWR  pfet_05v0  W=1.0u  L=0.5u

* n-FET evaluation tree: two NMOS in series.
* Stack: dyn -> XNA -> nint -> XNB -> foot_top -> XFOOT -> VGND.
* Internal node `nint` is exposed by name for charge-sharing probing.
XNA       dyn        A1    nint       VGND  nfet_05v0  W=0.8u  L=0.6u
XNB       nint       A2    foot_top   VGND  nfet_05v0  W=0.8u  L=0.6u

* Foot device (1): NMOS, gate=Clk. Cuts the n-tree from gnd during precharge.
XFOOT     foot_top   Clk   VGND       VGND  nfet_05v0  W=0.8u  L=0.6u

* ---------------------------------------------------------------
* Predriver pair (inverter from dyn -> out_b)
* ---------------------------------------------------------------
* Predriver-p sized 5x predriver-n to win the contention window during
* dyn-falling (paper sizing rule, p. 278; matches lsdl_inv_x1 tuning).
XPDRVP    out_b      dyn   VPWR       VPWR  pfet_05v0  W=3.0u  L=0.5u
XHDR      hdr_src    Clk   VGND       VGND  nfet_05v0  W=0.8u  L=0.6u
XPDRVN    out_b      dyn   hdr_src    VGND  nfet_05v0  W=0.4u  L=0.6u

* ---------------------------------------------------------------
* Latch keeper (feedback) and Cut feedback
* ---------------------------------------------------------------
XFBP      cut_fb_src Out   VPWR       VPWR  pfet_05v0  W=0.5u  L=0.5u
XCUTFB    out_b      Clk   cut_fb_src VPWR  pfet_05v0  W=0.5u  L=0.5u
XFBN      out_b      Out   VGND       VGND  nfet_05v0  W=0.5u  L=0.6u

* ---------------------------------------------------------------
* Output driver pair (inverter from out_b -> Out)
* ---------------------------------------------------------------
XODRVP    Out        out_b VPWR       VPWR  pfet_05v0  W=1.5u  L=0.5u
XODRVN    Out        out_b VGND       VGND  nfet_05v0  W=0.9u  L=0.6u

.ENDS lsdl_nand2_x1
