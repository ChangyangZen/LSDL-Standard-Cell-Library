* lsdl_inv_x1 — LSDL inverter, drive strength X1.
* Paper Fig. 1 (Belluomini et al., IBM J. Res. Dev. 50:2/3, 2006).
* Single-NMOS evaluation tree: dyn pulldown when A=1.
* Out = !A (semantically: positive-edge-triggered flop on Clk).
*
* GF180MCU 5V devices: pfet_05v0 (Lmin=0.5u), nfet_05v0 (Lmin=0.6u).
* Both are SUBCKTs in the PDK model file
* (libs.tech/ngspice/sm141064.ngspice), so we instantiate with X prefix.
* Port order is (d g s b) — same as a primitive MOSFET.
* W values are initial guesses, refined by Wave 0 characterization.

.SUBCKT lsdl_inv_x1 A Clk Out VPWR VGND

* ---------------------------------------------------------------
* Precharge stage
* ---------------------------------------------------------------
* Precharge device: PMOS, gate=Clk. dyn pulled to VPWR when Clk low.
XPRE      dyn        Clk   VPWR       VPWR  pfet_05v0  W=1.0u  L=0.5u

* n-FET evaluation tree (single NMOS for inverter).
* dyn -> A -> foot_top, then foot_top -> Clk -> VGND via foot device.
XNTREE    dyn        A     foot_top   VGND  nfet_05v0  W=0.8u  L=0.6u

* Foot device (1): NMOS, gate=Clk. Cuts the n-tree from gnd during
* precharge so inputs can switch freely (paper p. 278).
XFOOT     foot_top   Clk   VGND       VGND  nfet_05v0  W=0.8u  L=0.6u

* ---------------------------------------------------------------
* Predriver pair (inverter from dyn -> out_b)
* ---------------------------------------------------------------
* Predriver p: PMOS, gate=dyn. Pulls out_b high when dyn low.
* Must win against Predriver n + Header + Feedback n during the
* dyn-falling transition. PMOS intrinsically ~2.5x weaker than NMOS
* per unit width, so we size PMOS substantially wider than NMOS.
XPDRVP    out_b      dyn   VPWR       VPWR  pfet_05v0  W=3.0u  L=0.5u

* Header device: NMOS, gate=Clk. Source of Predriver n; prevents
* dyn rising during precharge from pulling out_b low.
XHDR      hdr_src    Clk   VGND       VGND  nfet_05v0  W=0.8u  L=0.6u

* Predriver n: NMOS, gate=dyn. Pulls out_b low (via Header) when dyn high.
* Sized small relative to Predriver p so PMOS wins the brief contention
* window at eval start (paper p. 278 glitch < 10% VDD rule).
XPDRVN    out_b      dyn   hdr_src    VGND  nfet_05v0  W=0.4u  L=0.6u

* ---------------------------------------------------------------
* Latch keeper (feedback) and Cut feedback
* ---------------------------------------------------------------
* Feedback device p: PMOS, gate=Out. Restores out_b high when Out=0.
XFBP      cut_fb_src Out   VPWR       VPWR  pfet_05v0  W=0.5u  L=0.5u

* Cut feedback: PMOS, gate=Clk. Prevents conflict between Feedback p
* and Predriver n during transitions.
XCUTFB    out_b      Clk   cut_fb_src VPWR  pfet_05v0  W=0.5u  L=0.5u

* Feedback device n: NMOS, gate=Out. Restores out_b low when Out=1.
XFBN      out_b      Out   VGND       VGND  nfet_05v0  W=0.5u  L=0.6u

* ---------------------------------------------------------------
* Output driver pair (inverter from out_b -> Out)
* ---------------------------------------------------------------
XODRVP    Out        out_b VPWR       VPWR  pfet_05v0  W=1.5u  L=0.5u
XODRVN    Out        out_b VGND       VGND  nfet_05v0  W=0.9u  L=0.6u

.ENDS lsdl_inv_x1
