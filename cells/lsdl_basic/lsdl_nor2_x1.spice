* lsdl_nor2_x1 — LSDL NOR2, drive strength X1.
* Paper Fig. 1. 2-NMOS PARALLEL eval tree. Out = !(A1 + A2).
* dyn discharges if ANY Ai=1. No internal stack node (parallel). GF180 5V.

.SUBCKT lsdl_nor2_x1 A1 A2 Clk Out VPWR VGND

XPRE      dyn        Clk   VPWR       VPWR  pfet_05v0  W=1.0u  L=0.5u

XNA      dyn        A1    foot_top   VGND  nfet_05v0  W=0.8u  L=0.6u
XNB      dyn        A2    foot_top   VGND  nfet_05v0  W=0.8u  L=0.6u
XFOOT     foot_top   Clk   VGND       VGND  nfet_05v0  W=0.8u  L=0.6u

XPDRVP    out_b      dyn   VPWR       VPWR  pfet_05v0  W=3.0u  L=0.5u
XHDR      hdr_src    Clk   VGND       VGND  nfet_05v0  W=0.8u  L=0.6u
XPDRVN    out_b      dyn   hdr_src    VGND  nfet_05v0  W=0.4u  L=0.6u
XFBP      cut_fb_src Out   VPWR       VPWR  pfet_05v0  W=0.5u  L=0.5u
XCUTFB    out_b      Clk   cut_fb_src VPWR  pfet_05v0  W=0.5u  L=0.5u
XFBN      out_b      Out   VGND       VGND  nfet_05v0  W=0.5u  L=0.6u
XODRVP    Out        out_b VPWR       VPWR  pfet_05v0  W=1.5u  L=0.5u
XODRVN    Out        out_b VGND       VGND  nfet_05v0  W=0.9u  L=0.6u

.ENDS lsdl_nor2_x1
