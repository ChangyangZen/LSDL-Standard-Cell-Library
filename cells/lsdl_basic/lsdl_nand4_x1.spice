* lsdl_nand4_x1 — LSDL NAND4, drive strength X1.
* Paper Fig. 1. 4-NMOS series eval tree. Out = !(A1 & A2 & A3 & A4).
* dyn discharges only when A1=A2=A3=A4=1. Stack nodes nint1..nint3 named.
* Eval NMOS width 1.2u (stack-height-4 scaling, paper ~1.5x guidance, capped
* for area). GF180MCU 5V: pfet_05v0 / nfet_05v0.

.SUBCKT lsdl_nand4_x1 A1 A2 A3 A4 Clk Out VPWR VGND

XPRE      dyn        Clk   VPWR       VPWR  pfet_05v0  W=1.0u  L=0.5u

* 4-series eval tree: dyn -> A1 -> nint1 -> A2 -> nint2 -> A3 -> nint3 -> A4 -> foot
XNA       dyn        A1    nint1      VGND  nfet_05v0  W=1.2u  L=0.6u
XNB       nint1      A2    nint2      VGND  nfet_05v0  W=1.2u  L=0.6u
XNC       nint2      A3    nint3      VGND  nfet_05v0  W=1.2u  L=0.6u
XND       nint3      A4    foot_top   VGND  nfet_05v0  W=1.2u  L=0.6u
XFOOT     foot_top   Clk   VGND       VGND  nfet_05v0  W=1.2u  L=0.6u

XPDRVP    out_b      dyn   VPWR       VPWR  pfet_05v0  W=3.0u  L=0.5u
XHDR      hdr_src    Clk   VGND       VGND  nfet_05v0  W=0.8u  L=0.6u
XPDRVN    out_b      dyn   hdr_src    VGND  nfet_05v0  W=0.4u  L=0.6u

XFBP      cut_fb_src Out   VPWR       VPWR  pfet_05v0  W=0.5u  L=0.5u
XCUTFB    out_b      Clk   cut_fb_src VPWR  pfet_05v0  W=0.5u  L=0.5u
XFBN      out_b      Out   VGND       VGND  nfet_05v0  W=0.5u  L=0.6u

XODRVP    Out        out_b VPWR       VPWR  pfet_05v0  W=1.5u  L=0.5u
XODRVN    Out        out_b VGND       VGND  nfet_05v0  W=0.9u  L=0.6u

.ENDS lsdl_nand4_x1
