* NGSPICE file created from row.ext - technology: gf180mcuD

.subckt row A1 A2 Clk Out VPWR VGND
X0 a_1730_1064# Clk a_612_24# VPWR pfet_05v0 ad=0.295p pd=1.68u as=1.2575p ps=4.18u w=0.5u l=0.5u
X1 a_2412_68# Clk VGND VGND nfet_05v0 ad=0.432p pd=1.88u as=0.576p ps=3.04u w=0.8u l=0.6u
X2 a_612_24# Out VGND VGND nfet_05v0 ad=0.252p pd=1.58u as=0.414p ps=1.98u w=0.5u l=0.6u
X3 a_1404_68# a_1284_24# a_612_24# VGND nfet_05v0 ad=0.36p pd=1.88u as=0.252p ps=1.58u w=0.4u l=0.6u
X4 VGND Clk a_1404_68# VGND nfet_05v0 ad=0.576p pd=3.04u as=0.36p ps=1.88u w=0.8u l=0.6u
X5 a_612_24# a_1284_24# VPWR VPWR pfet_05v0 ad=1.2575p pd=4.18u as=2.31p ps=7.54u w=3u l=0.5u
X6 a_1284_24# Clk VPWR VPWR pfet_05v0 ad=0.77p pd=3.54u as=0.4875p ps=2.18u w=1u l=0.5u
X7 Out a_612_24# VPWR VPWR pfet_05v0 ad=1.155p pd=4.54u as=1.155p ps=4.54u w=1.5u l=0.5u
X8 VGND a_612_24# Out VGND nfet_05v0 ad=0.414p pd=1.98u as=0.648p ps=3.24u w=0.9u l=0.6u
X9 a_2748_68# A2 a_2412_68# VGND nfet_05v0 ad=0.432p pd=1.88u as=0.432p ps=1.88u w=0.8u l=0.6u
X10 a_1284_24# A1 a_2748_68# VGND nfet_05v0 ad=0.576p pd=3.04u as=0.432p ps=1.88u w=0.8u l=0.6u
X11 VPWR Out a_1730_1064# VPWR pfet_05v0 ad=0.4875p pd=2.18u as=0.295p ps=1.68u w=0.5u l=0.5u
.ends
